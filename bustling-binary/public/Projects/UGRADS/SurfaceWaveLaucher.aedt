# Ansys Electronics Desktop project, version 2023.1
materials:
  Rogers RT/duroid 6010/6010LM (tm): permittivity=10.2 dielectric_loss_tangent=0.0023
  air: permittivity=1.0006 permeability=1.0000004
  pec: conductivity=1e+30
  vacuum: permittivity=1
  Teflon (tm): permittivity=2.1 dielectric_loss_tangent=0.001

design SWL Connor Port Edits (HFSS, HFSS Modal Network, model units mm)
variables:
  SubH = 1.575mm
  SubY = 150mm
  SubX = 33mm
  MicroX = 9mm
  MicoY = 3.05mm
  CondY = 50mm
  ViaR = 1mm
geometry:
  substrate [Rogers RT/duroid 6010/6010LM (tm)] = box(corner=(0mm, 5mm, 0mm), size=(65mm, -10mm, 1.5mm))
  MicroStrip = rectangle(corner=(0mm, (-1.625/2) mm, 1.9mm), x_size=1.625mm, y_size=1.625mm)
  Polyline1 = polyline(z=1.9mm, xy in mm: (1.625, -0.8125) (2.4356, -1.625) (2.4356, 1.625) (1.625, 0.8125) (1.625, -0.8125), closed, covered)
  Rectangle2 = rectangle(corner=(2.4356mm, -1.625mm, 1.9mm), x_size=15.06mm, y_size=3.25mm)
  MicroStrip.unite(Polyline1, Rectangle2)
  Rectangle3 = rectangle(corner=(17.576mm, -1.634mm, 1.9mm), x_size=0.76mm, y_size=0.76mm)
  Rectangle4 = rectangle(corner=(17.576mm, -0.798mm, 1.9mm), x_size=0.76mm, y_size=0.76mm)
  Rectangle5 = rectangle(corner=(17.576mm, 0.038mm, 1.9mm), x_size=0.76mm, y_size=0.76mm)
  Rectangle6 = rectangle(corner=(17.576mm, 0.874mm, 1.9mm), x_size=0.76mm, y_size=0.76mm)
  Rectangle7 = rectangle(corner=(18.412mm, -1.634mm, 1.9mm), x_size=0.76mm, y_size=0.76mm)
  Rectangle8 = rectangle(corner=(18.412mm, -0.798mm, 1.9mm), x_size=0.76mm, y_size=0.76mm)
  Rectangle9 = rectangle(corner=(18.412mm, 0.038mm, 1.9mm), x_size=0.76mm, y_size=0.76mm)
  Rectangle10 = rectangle(corner=(18.412mm, 0.874mm, 1.9mm), x_size=0.76mm, y_size=0.76mm)
  Rectangle11 = rectangle(corner=(19.248mm, -1.634mm, 1.9mm), x_size=0.76mm, y_size=0.76mm)
  Rectangle12 = rectangle(corner=(19.248mm, -0.798mm, 1.9mm), x_size=0.76mm, y_size=0.76mm)
  Rectangle13 = rectangle(corner=(19.248mm, 0.038mm, 1.9mm), x_size=0.76mm, y_size=0.76mm)
  Rectangle14 = rectangle(corner=(19.248mm, 0.874mm, 1.9mm), x_size=0.76mm, y_size=0.76mm)
  Rectangle15 = rectangle(corner=(20.084mm, -1.634mm, 1.9mm), x_size=0.76mm, y_size=0.76mm)
  Rectangle16 = rectangle(corner=(20.084mm, -0.798mm, 1.9mm), x_size=0.76mm, y_size=0.76mm)
  Rectangle17 = rectangle(corner=(20.084mm, 0.038mm, 1.9mm), x_size=0.76mm, y_size=0.76mm)
  Rectangle18 = rectangle(corner=(20.084mm, 0.874mm, 1.9mm), x_size=0.76mm, y_size=0.76mm)
  Rectangle3.unite(Rectangle4..Rectangle18)
  MicroStrip_1 = MicroStrip.duplicate_mirror(point=(32.5mm, 0mm, 0mm), normal=(-1mm, 0mm, 0mm))
  Rectangle3_1 = Rectangle3.duplicate_mirror(point=(32.5mm, 0mm, 0mm), normal=(-1mm, 0mm, 0mm))
  [substrate, MicroStrip, Rectangle3, MicroStrip_1, Rectangle3_1].move(0mm, 0mm, 1mm)
  [MicroStrip_1, Rectangle3_1, Rectangle3, MicroStrip].move(0mm, 0mm, -0.4mm)
  coordinate_system RelativeCS1 = origin=(0mm, 5mm, 1mm) x=(1mm, 0mm, 0mm) y=(0mm, 1mm, 0mm)
  coordinate_system RelativeCS2 = origin=(0mm, 0mm, 1.5mm) x=(1mm, 0mm, 0mm) y=(0mm, 1mm, 0mm) in RelativeCS1
  [substrate, MicroStrip].scale(1.23, 1.23, 1.23) in RelativeCS2
  MicroStrip.delete()
  [Rectangle3, MicroStrip_1, Rectangle3_1].scale(1.23, 1.23, 1.23) in RelativeCS2
  Box1 = box(corner=(79.95mm, -12.3mm, -1.845mm), size=(6mm, 12.3mm, 1.845mm)) in RelativeCS2
  Box2 = box(corner=(0mm, -12.3mm, -1.845mm), size=(-6mm, 12.3mm, 1.845mm)) in RelativeCS2
  Microstrip_3 = rectangle(corner=(79.95mm, -7.149375mm, 0mm), x_size=6mm, y_size=1.99875mm) in RelativeCS2
  substrate.unite(Box2, Box1)
  GND = rectangle(corner=(-6mm, 0mm, -1.845mm), x_size=91.95mm, y_size=-12.3mm) in RelativeCS2
  Microstrip_3.unite(MicroStrip_1)
  Rectangle26 [non-model] = rectangle(corner=(85.95mm, -12.3mm, 0mm), x_size=-91.95mm, y_size=12.3mm) in RelativeCS2
  Rectangle27 = rectangle(corner=(85.95mm, -7.149375mm, 0mm), x_size=-0.55mm, y_size=2mm) in RelativeCS2
  Polyline2 = polyline(z=0mm, xy in mm: (85.95, -5.7) (85.4, -5.150975) (85.4, -7.149375) (85.95, -6.6) (85.95, -5.7), closed, covered) in RelativeCS2
  Microstrip_3.subtract(Rectangle27)
  Microstrip_3.unite(Polyline2)
  coordinate_system RelativeCS3 = origin=(-6mm, -12.3mm, -1.845mm) x=(1mm, 0mm, 0mm) y=(0mm, 1mm, 0mm) in RelativeCS2
  coordinate_system RelativeCS4 = origin=(0mm, 0mm, 1.845mm) x=(1mm, 0mm, 0mm) y=(0mm, 1mm, 0mm) in RelativeCS3
  Microstrip1 = Microstrip_3.duplicate_mirror(point=(45.975mm, 0mm, 0mm), normal=(-1mm, 0mm, 0mm)) in RelativeCS4
  Cylinder1 = cylinder(axis=Z, base_centre=(2.38mm, 2.725mm, 0.01mm), radius=0.75mm, height=-1.9mm) in RelativeCS4
  Cylinder2 = cylinder(axis=Z, base_centre=(2.38mm, 9.575mm, 0.01mm), radius=0.75mm, height=-1.9mm) in RelativeCS4
  Cylinder1_1 = Cylinder1.duplicate_mirror(point=(45.975mm, 0mm, 0mm), normal=(-1mm, 0mm, 0mm)) in RelativeCS4
  Cylinder2_1 = Cylinder2.duplicate_mirror(point=(45.975mm, 0mm, 0mm), normal=(-1mm, 0mm, 0mm)) in RelativeCS4
  Cylinder1_2 = Cylinder1.copy()
  Cylinder1_1_1 = Cylinder1_1.copy()
  Cylinder2_2 = Cylinder2.copy()
  Cylinder2_1_1 = Cylinder2_1.copy()
  GND.subtract(Cylinder1_2, Cylinder1_1_1, Cylinder2_2, Cylinder2_1_1)
  substrate.subtract(Cylinder1, Cylinder1_1, Cylinder2, Cylinder2_1)
  Dielectric = cylinder(axis=X, base_centre=(91.95mm, 6.15mm, 2.226mm), radius=2.159mm, height=8.763mm) in RelativeCS3
  Cylinder4 = cylinder(axis=X, base_centre=(86.5652mm, 6.15mm, 2.226mm), radius=0.381mm, height=14.1478mm) in RelativeCS3
  Conductor = cylinder(axis=X, base_centre=(86.5652mm, 6.15mm, 2.226mm), radius=0.381mm, height=14.1478mm) in RelativeCS3
  Dielectric.subtract(Cylinder4)
  Dielectric_1 [Teflon (tm)] = Dielectric.duplicate_mirror(point=(45.975mm, 0mm, 0mm), normal=(1mm, 0mm, 0mm)) in RelativeCS3
  Dielectric.delete()
  Conductor_1 [pec] = Conductor.duplicate_mirror(point=(45.975mm, 0mm, 0mm), normal=(1mm, 0mm, 0mm)) in RelativeCS3
  Conductor.delete()
  RadBox [air] = box(corner=(-8.763mm, 20mm, -3mm), size=(109.476mm, -27mm, 25mm)) in RelativeCS3
  NONE = imported_body(C:\Users\Administrator\Downloads\PE44206_3D (1).step) in RelativeCS3
  NONE.rotate(axis=Z, angle=-90deg) in RelativeCS3
  NONE.rotate(axis=Y, angle=-90deg) in RelativeCS3
  NONE.move(-1.27mm, 6.15mm, 2.226mm) in RelativeCS3
  NONE_1 = NONE.copy()
  Conductor_1.subtract(NONE_1)
  Box3 = box(corner=(-8.763mm, -7mm, -3mm), size=(-5.237mm, 27mm, 13mm)) in RelativeCS3
  NONE.subtract(Box3)
  substrate_1 = substrate.copy()
  NONE.subtract(substrate_1)
  Dielectric_1_2 = Dielectric_1.copy()
  NONE.subtract(Dielectric_1_2)
  NONE_Separate1 [pec] = NONE.separate_bodies()
  Conductor_1.unite(NONE)
  NONE_Separate1_1 [pec] = NONE_Separate1.duplicate_mirror(point=(45.975mm, 0mm, 0mm), normal=(-1mm, 0mm, 0mm)) in RelativeCS3
  Conductor_1_1 [pec] = Conductor_1.duplicate_mirror(point=(45.975mm, 0mm, 0mm), normal=(-1mm, 0mm, 0mm)) in RelativeCS3
  Dielectric_1_3 [Teflon (tm)] = Dielectric_1.duplicate_mirror(point=(45.975mm, 0mm, 0mm), normal=(-1mm, 0mm, 0mm)) in RelativeCS3
  Rectangle26.move(0mm, 0mm, 0.2mm) in RelativeCS3
boundaries and excitations:
  PerfE3: Perfect E Objects=Rectangle3
  PerfE5: Perfect E Objects=Rectangle3_1
  PerfE6: Perfect E Objects=GND
  PerfE7: Perfect E Objects=Microstrip_3
  PerfE8: Perfect E Objects=Microstrip1
  Rad1: Radiation Faces=RadBox.face(at (39.975, 12.7, 10.155), at (39.975, -0.8, 22.655), at (39.975, -14.3, 10.155), at (39.975, -0.8, -2.345))
  1: Wave Port Faces=Dielectric_1.face(at (-14.763, -1.15, 2.881)) WavePortType=Modal NumModes=1 Modes{Mode1{CharImp=Zpi RenormImp=50ohm}}
  2: Wave Port Faces=Dielectric_1_3.face(at (94.713, -1.15, 2.881)) WavePortType=Modal NumModes=1 Modes{Mode1{CharImp=Zpi RenormImp=50ohm}}
setups:
  Setup1: HfssDriven Frequency=12.5GHz MaxDeltaS=0.0075 MaximumPasses=99 MinimumPasses=3 MinimumConvergedPasses=3 PercentRefinement=30 BasisOrder=1 PortAccuracy=2 DrivenSolverType="Direct Solver" ConstantDelta=0s
    sweep Sweep: 11GHz to 15GHz, 401 points; Type=Discrete SaveFields
  Setup2: HfssDriven Frequency=22.5GHz MaxDeltaS=0.02 MaximumPasses=30 MinimumPasses=3 MinimumConvergedPasses=2 PercentRefinement=30 BasisOrder=1 PortAccuracy=2 DrivenSolverType="Direct Solver"
    sweep Sweep: 7.5GHz to 22.5GHz, 401 points; Type=Interpolating InterpTolerance=0.5 InterpMaxSolns=250 InterpUsePortImped=false PassivityErrorTolerance=0.0001
source amplitudes:
  1:1: 1V 0deg
  2:1: 0W 0deg
field calculator expressions:
  Ez = Fundamental_Quantity(0) | ScalarZ | Scalar_Function(FuncValue='Phase') | AtPhase
field plots:
  Mag_E1: E Field over a plane on Setup1 : Sweep at Freq=3GHz Phase=0deg
  Ez1: NamedExpr over a plane on Setup1 : Sweep at Freq=3GHz Phase=0deg
reports:
  Terminal S Parameter Plot 1: dB(St(2,1)), dB(St(1,1)), dB(St(1,2)), dB(St(2,2)) vs Freq on Setup1 : Sweep; markers m2 at 12.35GHz
